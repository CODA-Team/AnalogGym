ocnxlSweepVar("c_cbank_half_cell" "4.165u")
ocnxlSweepVar("c_cvar" "4.63u")
ocnxlSweepVar("c_load" "4.63u")
ocnxlSweepVar("l_bias1" "100n")
ocnxlSweepVar("l_bias2" "100n")
ocnxlSweepVar("l_cbank_half_cell" "100n")
ocnxlSweepVar("l_cvar" "400n")
ocnxlSweepVar("l_load" "100n")
ocnxlSweepVar("r_cvar" "5K")
ocnxlSweepVar("w_bias1" "10u")
ocnxlSweepVar("w_bias2" "10u")
ocnxlSweepVar("w_cbank_half_cell" "1u")
ocnxlSweepVar("w_cvar" "4.5u")
ocnxlSweepVar("w_load" "1u")
